* NGSPICE file created from rl_pc.ext - technology: sky130A

.subckt sky130_fd_pr__res_high_po_1p41_CPXBP6 B R1 R2
X0 R2 R1 B sky130_fd_pr__res_high_po_1p41 l=216.405
.ends

.subckt rl_pc
XX0 VSUBS X0/R1 X0/R2 sky130_fd_pr__res_high_po_1p41_CPXBP6
.ends
