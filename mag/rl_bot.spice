* NGSPICE file created from rl_bot.ext - technology: sky130A

.subckt sky130_fd_pr__res_high_po_1p41_TGLABR B R1 R2
X0 R2 R1 B sky130_fd_pr__res_high_po_1p41 l=172.78
.ends

.subckt rl_bot
XX0 VSUBS X0/R1 X0/R2 sky130_fd_pr__res_high_po_1p41_TGLABR
.ends
