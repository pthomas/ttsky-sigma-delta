* NGSPICE file created from rdac.ext - technology: sky130A

.subckt sky130_fd_pr__res_high_po_1p41_W7ZD8Q B R1 R2
X0 R2 R1 B sky130_fd_pr__res_high_po_1p41 l=88.29
.ends

.subckt rdac
XX0 VSUBS X0/R1 X0/R2 sky130_fd_pr__res_high_po_1p41_W7ZD8Q
.ends
