* NGSPICE file created from rin.ext - technology: sky130A

.subckt sky130_fd_pr__res_high_po_0p35_BA75HG B R1 R2
X0 R2 R1 B sky130_fd_pr__res_high_po_0p35 l=102.57
.ends

.subckt rin
XX0 VSUBS X0/R1 X0/R2 sky130_fd_pr__res_high_po_0p35_BA75HG
.ends
